* NeuroChain U5: amplifier saturation and recovery after a stimulation pulse
* Generated by neurochain.frontend.spice; do not edit by hand.
.options temp=37 tnom=27 reltol=1e-5 vntol=1e-9 abstol=1e-16 chgtol=1e-19
Vsig tissue 0 PWL(0 0 2e-06 -0.03 0.0002 -0.03 0.000202 0 0.0003 0 0.000302 0.01485 0.0007 0.01485 0.000702 6e-05 0.000868666667 5.07889035e-05 0.00103533333 4.29918786e-05 0.001202 3.63918396e-05 0.00136866667 3.08050271e-05 0.00153533333 2.60758925e-05 0.001702 2.20727665e-05 0.00186866667 1.86841934e-05 0.00203533333 1.58158283e-05 0.002202 1.33878096e-05 0.00236866667 1.13325362e-05 0.00253533333 9.59278476e-06 0.002702 8.12011699e-06 0.00286866667 6.87353064e-06 0.00303533333 5.81831807e-06 0.003202 4.92509992e-06 0.00336866667 4.16900707e-06 0.00353533333 3.5289883e-06 0.003702 2.9872241e-06 0.00386866667 2.52863061e-06 0.00403533333 2.1404396e-06 0.004202 1.81184301e-06 0.00436866667 1.53369199e-06 0.00453533333 1.29824224e-06 0.004702 1.09893833e-06 0.00486866667 9.30231216e-07 0.00503533333 7.87423724e-07 0.005202 6.66539792e-07 0.00536866667 5.64213753e-07 0.00553533333 4.77596631e-07 0.005702 4.0427682e-07 0.00586866667 3.4221294e-07 0.00603533333 2.89677e-07 0.006202 2.45206286e-07 0.00636866667 2.0756264e-07 0.00653533333 1.75697982e-07 0.006702 1.48725131e-07 0.00686866667 1.25893105e-07 0.00703533333 1.06566213e-07 0.007202 9.02063516e-08 0.00736866667 7.63580281e-08 0.00753533333 6.46356753e-08 0.007702 5.47129179e-08 0.00786866667 4.63134851e-08 0.00803533333 3.92035188e-08 0.008202 3.31850622e-08 0.00836866667 2.80905487e-08 0.00853533333 2.37781361e-08 0.008702 2.01277577e-08 0.00886866667 0)
* Utah Pt, in saline: Rs, then Rct in parallel with the double layer
Rs tissue iface 7300
Rct iface pad 4.6e+09
* Constant-phase element Q=7.2e-09 n=0.74 as an RC ladder
Rlow iface pad 2.88859833e+10
Chigh iface pad 5.19267747e-11
Rb0 iface b0 2.2144697e+10
Cb0 b0 pad 7.18704541e-09
Rb1 iface b1 9.4464742e+09
Cb1 b1 pad 5.32783037e-09
Rb2 iface b2 4.02967242e+09
Cb2 b2 pad 3.94957522e-09
Rb3 iface b3 1.71897572e+09
Cb3 b3 pad 2.92786056e-09
Rb4 iface b4 733279836
Cb4 b4 pad 2.17045302e-09
Rb5 iface b5 312802159
Cb5 b5 pad 1.60897905e-09
Rb6 iface b6 133434995
Cb6 b6 pad 1.19275265e-09
Rb7 iface b7 56920635.8
Cb7 b7 pad 8.84199753e-10
Rb8 iface b8 24281177.4
Cb8 b8 pad 6.55466332e-10
Rb9 iface b9 10357853
Cb9 b9 pad 4.85903905e-10
Rb10 iface b10 4418447.94
Cb10 b10 pad 3.60205541e-10
Rb11 iface b11 1884819.4
Cb11 b11 pad 2.67024056e-10
Rb12 iface b12 804025.352
Cb12 b12 pad 1.97947668e-10
Rb13 iface b13 342980.748
Cb13 b13 pad 1.46740633e-10
Rb14 iface b14 146308.562
Cb14 b14 pad 1.08780334e-10
Rb15 iface b15 62412.2361
Cb15 b15 pad 8.06399758e-11
Rb16 iface b16 26623.7816
Cb16 b16 pad 5.977924e-11
Rb17 iface b17 11357.16
Cb17 b17 pad 4.43149628e-11
Rb18 iface b18 4844.73183
Cb18 b18 pad 3.28511358e-11
Rb19 iface b19 2066.66337
Cb19 b19 pad 2.43528834e-11
Rb20 iface b20 881.596267
Cb20 b20 pad 1.80530419e-11
* Capacitive feedback network: gain C1/C2, high-pass corner 1/(2 pi R2 C2)
C1 pad x 2e-11
Cin x 0 2e-12
C2 x out 2e-13
R2 x out 2.65258238e+09
* OTA: a weak-inversion pair steers at most its tail current into Ro and CL
Bota out 0 I = 1.25e-07 * tanh(1.63694234e-06 * v(x) / 1.25e-07)
Ro out 0 6.10895065e+09
CL out 0 2.94657187e-12
* Rails: a stiff conductance that only conducts beyond the output swing
Bclamp out 0 I = 0.001 * (max(v(out) - 0.8, 0) + min(v(out) + 0.8, 0))
.control
set wr_singlescale
set wr_vecnames
tran 5e-06 0.03 0 5e-06
wrdata transient.spice.txt v(out) v(x)
quit
.endc
.end
